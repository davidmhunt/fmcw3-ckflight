RC low-pass, fc = 1/(2 pi R C) = 1 kHz
V1 in 0 DC 0 AC 1
R1 in out 1k
C1 out 0 159.15494n
.control
ac dec 50 10 100k
meas ac g_fc find vdb(out) at=1k
meas ac g_dec find vdb(out) at=10k
meas ac g_lo find vdb(out) at=10
.endc
.end
